* Analog Atlas - ring - GENERIC TEACHING MODEL
* No foundry devices. Not TSMC / PDK validation.
* Analytic and behavioral assumptions are documented in Analog Atlas.
.options reltol=1e-8 abstol=1e-14 vntol=1e-10
.param VDD=1.800000000e+0
B1 d1 0 V={VDD/2*(1-tanh((V(n5)-VDD/2)*20))}
R1 d1 n1 1.851851852e+3
C1 n1 0 1.000000000e-13 IC=1.000000000e-2
B2 d2 0 V={VDD/2*(1-tanh((V(n1)-VDD/2)*20))}
R2 d2 n2 1.851851852e+3
C2 n2 0 1.000000000e-13 IC=9.000000000e-1
B3 d3 0 V={VDD/2*(1-tanh((V(n2)-VDD/2)*20))}
R3 d3 n3 1.851851852e+3
C3 n3 0 1.000000000e-13 IC=9.000000000e-1
B4 d4 0 V={VDD/2*(1-tanh((V(n3)-VDD/2)*20))}
R4 d4 n4 1.851851852e+3
C4 n4 0 1.000000000e-13 IC=9.000000000e-1
B5 d5 0 V={VDD/2*(1-tanh((V(n4)-VDD/2)*20))}
R5 d5 n5 1.851851852e+3
C5 n5 0 1.000000000e-13 IC=9.000000000e-1
* Starved export assumes crossing excursion = 0.5 VDD (UI input: n/a).
* Behavioral saturation/clamps cause small departures from ideal timing.
.tran 8.518518519e-12 3.194444444e-8 UIC
.save v(n1) v(n2)
.end
