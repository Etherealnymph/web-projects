* Analog Atlas - beta - GENERIC TEACHING MODEL
* No foundry devices. Not TSMC / PDK validation.
* Analytic and behavioral assumptions are documented in Analog Atlas.
.options reltol=1e-8 abstol=1e-14 vntol=1e-10
* Behavioral temperature transfer only, not a transistor reference circuit.
Vtemp temperature 0 2.700000000e+1
Breference 0 out I={5.000000000e-1/(4.000000000e-4*(3.001500000e+2/(V(temperature)+273.15))^1.500000000e+0*(1.000000000e+4*(1+1.000000000e-4*(V(temperature)-2.700000000e+1)))^2)}
Rreadout out 0 1k
* Iref = V(out)/1000; no compliance or load regulation model.
.dc Vtemp -40 125 1
.save v(out) v(temperature)
.end
